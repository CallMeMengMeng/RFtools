// Module: tline

// Generated by MATLAB(R) 9.5 and the RF Toolbox 3.5.

// Generated on: 10-Feb-2020 15:36:11

`include "disciplines.vams"

module tline(tline_in, tline_out);
 electrical tline_in, tline_out;

 real nn1[0:1], nn2[0:1], nn3[0:1], nn4[0:0];
 real dd1[0:2], dd2[0:2], dd3[0:2], dd4[0:1];

 analog begin

   @(initial_step) begin
     nn1[0] = -7.4156153299e+17;
     nn1[1] = -6.8179679926e+08;
     dd1[0] = 3.4536120750e+20;
     dd1[1] = 7.0342776768e+08;
     dd1[2] = 1.0000000000e+00;
     nn2[0] = 2.6469859780e+17;
     nn2[1] = 7.9110464584e+08;
     dd2[0] = 1.5438243504e+20;
     dd2[1] = 7.8637022345e+08;
     dd2[2] = 1.0000000000e+00;
     nn3[0] = -1.0906415861e+17;
     nn3[1] = -7.8685669844e+08;
     dd3[0] = 3.8632994704e+19;
     dd3[1] = 7.6957951533e+08;
     dd3[2] = 1.0000000000e+00;
     nn4[0] = 3.3305070367e+08;
     dd4[0] = 2.1845704647e+09;
     dd4[1] = 1.0000000000e+00;
   end

   V(tline_out) <+ laplace_nd(V(tline_in), nn1, dd1);
   V(tline_out) <+ laplace_nd(V(tline_in), nn2, dd2);
   V(tline_out) <+ laplace_nd(V(tline_in), nn3, dd3);
   V(tline_out) <+ laplace_nd(V(tline_in), nn4, dd4);
 end
endmodule
